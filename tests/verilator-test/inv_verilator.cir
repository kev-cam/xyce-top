* Inverter test using Verilator-based digital model
.title Verilator Inverter Test

* Load external Verilator model
.external verilator_inv.so

* Input stimulus - pulse waveform
Vin in 0 PULSE(0 1 1n 0.1n 0.1n 5n 10n)

* Inverter using Verilator model
* YPWL format: YPWL <name> <node> <function> <args>
YPWL INV_IN in ConnectVerilatorInv input
YPWL INV_OUT out ConnectVerilatorInv output

* Load resistor
Rload out 0 1k

* Transient analysis
.tran 0.1n 20n

* Output
.print tran v(in) v(out)

.end
