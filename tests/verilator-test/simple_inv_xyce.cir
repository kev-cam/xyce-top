* Auto-generated Xyce netlist for Verilator module: simple_inv
* Generated by verilog2xyce.pl

.title simple_inv Verilator Test

* Input stimulus for in
Vin_in in_node 0 PULSE(0 1 1n 0.1n 0.1n 5n 10n)

* simple_inv device using Verilator (ports via PWL bridge)
YPWL simple_inv_in in_node file://simple_inv_xyce.so!ConnectSimple_inv in
YPWL simple_inv_out out_node file://simple_inv_xyce.so!ConnectSimple_inv out

Rload_out out_node 0 1k

* Transient analysis
.tran 0.1n 30n

* Output
.print tran v(in_node) v(out_node)

.end
